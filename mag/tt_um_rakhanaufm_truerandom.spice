* SPICE3 file created from tt_um_rakhanaufm_truerandom.ext - technology: sky130A

.subckt sky130_fd_pr__nfet_01v8_MH3LLV B D S G
X0 S G D B sky130_fd_pr__nfet_01v8 ad=0.29 pd=2.58 as=0.29 ps=2.58 w=1 l=0.15
.ends

.subckt sky130_fd_pr__pfet_01v8_A6MZLZ B D S G
X0 S G D B sky130_fd_pr__pfet_01v8 ad=0.58 pd=4.58 as=0.58 ps=4.58 w=2 l=0.15
.ends

.subckt XOR XM6/G XM9/G VSUBS XM7/S XM9/S
XXM1 VSUBS XM9/D VSUBS XM9/G sky130_fd_pr__nfet_01v8_MH3LLV
XXM2 XM9/S XM9/S XM7/G XM6/G sky130_fd_pr__pfet_01v8_A6MZLZ
XXM3 XM9/S XM9/D XM7/S XM7/G sky130_fd_pr__pfet_01v8_A6MZLZ
XXM4 XM9/S XM7/S XM9/G XM6/G sky130_fd_pr__pfet_01v8_A6MZLZ
XXM5 VSUBS XM7/S XM9/D XM6/G sky130_fd_pr__nfet_01v8_MH3LLV
XXM6 VSUBS VSUBS XM7/G XM6/G sky130_fd_pr__nfet_01v8_MH3LLV
XXM7 VSUBS XM9/G XM7/S XM7/G sky130_fd_pr__nfet_01v8_MH3LLV
XXM9 XM9/S XM9/D XM9/S XM9/G sky130_fd_pr__pfet_01v8_A6MZLZ
.ends

.subckt sky130_fd_pr__nfet_01v8_45YRG6 B D S G
X0 S G D B sky130_fd_pr__nfet_01v8 ad=0.145 pd=1.58 as=0.145 ps=1.58 w=0.5 l=0.15
.ends

.subckt sky130_fd_pr__nfet_01v8_7TC9PA B D S G
X0 S G D B sky130_fd_pr__nfet_01v8 ad=0.145 pd=1.58 as=0.145 ps=1.58 w=0.5 l=0.5
.ends

.subckt sky130_fd_pr__pfet_01v8_T4HHSR B D S G
X0 S G D B sky130_fd_pr__pfet_01v8 ad=0.29 pd=2.58 as=0.29 ps=2.58 w=1 l=0.5
.ends

.subckt sky130_fd_pr__pfet_01v8_TMVPE9 B D S G
X0 S G D B sky130_fd_pr__pfet_01v8 ad=0.29 pd=2.58 as=0.29 ps=2.58 w=1 l=0.15
.ends

.subckt VCO XM9/G XM2/G XM6/S VSUBS
XXM12 VSUBS XM6/G VSUBS XM9/G sky130_fd_pr__nfet_01v8_45YRG6
XXM14 XM6/S XM5/D XM8/S XM8/G sky130_fd_pr__pfet_01v8_A6MZLZ
XXM13 VSUBS XM16/D XM2/G XM21/S sky130_fd_pr__nfet_01v8_MH3LLV
XXM15 VSUBS XM9/D XM7/G XM2/G sky130_fd_pr__nfet_01v8_MH3LLV
XXM16 VSUBS XM16/D VSUBS XM9/G sky130_fd_pr__nfet_01v8_7TC9PA
XXM17 XM6/S XM18/D XM2/G XM21/S sky130_fd_pr__pfet_01v8_A6MZLZ
XXM18 XM6/S XM18/D XM6/S XM6/G sky130_fd_pr__pfet_01v8_T4HHSR
XXM19 VSUBS XM20/D XM21/S XM8/S sky130_fd_pr__nfet_01v8_MH3LLV
XXM1 XM6/S XM4/D XM8/G XM7/G sky130_fd_pr__pfet_01v8_A6MZLZ
XXM2 XM6/S XM3/D XM7/G XM2/G sky130_fd_pr__pfet_01v8_A6MZLZ
XXM3 XM6/S XM3/D XM6/S XM6/G sky130_fd_pr__pfet_01v8_T4HHSR
XXM4 XM6/S XM4/D XM6/S XM6/G sky130_fd_pr__pfet_01v8_T4HHSR
XXM5 XM6/S XM5/D XM6/S XM6/G sky130_fd_pr__pfet_01v8_T4HHSR
XXM6 XM6/S XM6/G XM6/S XM6/G sky130_fd_pr__pfet_01v8_TMVPE9
XXM7 VSUBS XM7/D XM8/G XM7/G sky130_fd_pr__nfet_01v8_MH3LLV
XXM8 VSUBS XM8/D XM8/S XM8/G sky130_fd_pr__nfet_01v8_MH3LLV
XXM9 VSUBS XM9/D VSUBS XM9/G sky130_fd_pr__nfet_01v8_7TC9PA
XXM20 VSUBS XM20/D VSUBS XM9/G sky130_fd_pr__nfet_01v8_7TC9PA
XXM21 XM6/S XM22/D XM21/S XM8/S sky130_fd_pr__pfet_01v8_A6MZLZ
XXM10 VSUBS XM7/D VSUBS XM9/G sky130_fd_pr__nfet_01v8_7TC9PA
XXM22 XM6/S XM22/D XM6/S XM6/G sky130_fd_pr__pfet_01v8_T4HHSR
XXM11 VSUBS XM8/D VSUBS XM9/G sky130_fd_pr__nfet_01v8_7TC9PA
.ends

.subckt sky130_fd_pr__pfet_01v8_FNQE4J B D S G
X0 S G D B sky130_fd_pr__pfet_01v8 ad=1.16 pd=8.58 as=1.16 ps=8.58 w=4 l=0.15
.ends

.subckt sky130_fd_pr__nfet_01v8_33NS5F B D S G
X0 S G D B sky130_fd_pr__nfet_01v8 ad=0.58 pd=4.58 as=0.58 ps=4.58 w=2 l=0.15
.ends

.subckt sky130_fd_pr__pfet_01v8_XAKWQW B D S G
X0 S G D B sky130_fd_pr__pfet_01v8 ad=4.64 pd=32.58 as=4.64 ps=32.58 w=16 l=0.15
.ends

.subckt sky130_fd_pr__nfet_01v8_77S659 B D S G
X0 S G D B sky130_fd_pr__nfet_01v8 ad=2.32 pd=16.58 as=2.32 ps=16.58 w=8 l=0.15
.ends

.subckt sky130_fd_pr__pfet_01v8_U2FPYB B D S G
X0 S G D B sky130_fd_pr__pfet_01v8 ad=2.32 pd=16.58 as=2.32 ps=16.58 w=8 l=0.15
.ends

.subckt sky130_fd_pr__nfet_01v8_WK9H77 B D S G
X0 S G D B sky130_fd_pr__nfet_01v8 ad=1.16 pd=8.58 as=1.16 ps=8.58 w=4 l=0.15
.ends

.subckt BUFFER XM6/S XM7/D XM5/G VSUBS
XXM1 XM7/D XM7/D XM8/G XM5/S sky130_fd_pr__pfet_01v8_FNQE4J
XXM2 VSUBS VSUBS XM8/G XM5/S sky130_fd_pr__nfet_01v8_33NS5F
XXM3 VSUBS VSUBS XM5/S XM5/G sky130_fd_pr__nfet_01v8_MH3LLV
XXM4 XM7/D XM7/D XM6/S XM8/S sky130_fd_pr__pfet_01v8_XAKWQW
XXM5 XM7/D XM7/D XM5/S XM5/G sky130_fd_pr__pfet_01v8_A6MZLZ
XXM6 VSUBS VSUBS XM6/S XM8/S sky130_fd_pr__nfet_01v8_77S659
XXM7 XM7/D XM7/D XM8/S XM8/G sky130_fd_pr__pfet_01v8_U2FPYB
XXM8 VSUBS VSUBS XM8/S XM8/G sky130_fd_pr__nfet_01v8_WK9H77
.ends

.subckt sky130_fd_pr__pfet_01v8_LE4Y8H B D S G
X0 S G D B sky130_fd_pr__pfet_01v8 ad=1.74 pd=12.58 as=1.74 ps=12.58 w=6 l=0.15
.ends

.subckt sky130_fd_pr__nfet_01v8_GM8MVP B D S G
X0 S G D B sky130_fd_pr__nfet_01v8 ad=0.87 pd=6.58 as=0.87 ps=6.58 w=3 l=0.15
.ends

.subckt DFLIPFLOP XM7/G VSUBS XM8/G XM9/S XM6/D
XXM1 XM6/D XM7/D XM2/S XM8/G sky130_fd_pr__pfet_01v8_LE4Y8H
XXM2 XM6/D XM6/D XM2/S XM7/G sky130_fd_pr__pfet_01v8_LE4Y8H
XXM3 XM6/D XM6/D XM5/G XM8/G sky130_fd_pr__pfet_01v8_LE4Y8H
XXM4 VSUBS XM4/D XM5/G XM7/D sky130_fd_pr__nfet_01v8_GM8MVP
XXM5 XM6/D XM6/D XM9/G XM5/G sky130_fd_pr__pfet_01v8_LE4Y8H
XXM6 XM6/D XM6/D XM9/S XM9/G sky130_fd_pr__pfet_01v8_LE4Y8H
XXM7 VSUBS XM7/D VSUBS XM7/G sky130_fd_pr__nfet_01v8_GM8MVP
XXM9 VSUBS VSUBS XM9/S XM9/G sky130_fd_pr__nfet_01v8_GM8MVP
XXM8 VSUBS XM8/D XM9/G XM8/G sky130_fd_pr__nfet_01v8_GM8MVP
XXM10 VSUBS XM4/D VSUBS XM8/G sky130_fd_pr__nfet_01v8_GM8MVP
XXM11 VSUBS XM8/D VSUBS XM5/G sky130_fd_pr__nfet_01v8_GM8MVP
.ends

.subckt tt_um_rakhanaufm_truerandom clk ena rst_n ua[0] ua[1] ua[2] ua[3] ua[4] ua[5]
+ ua[6] ua[7] ui_in[0] ui_in[1] ui_in[2] ui_in[3] ui_in[4] ui_in[5] ui_in[6] ui_in[7]
+ uio_in[0] uio_in[1] uio_in[2] uio_in[3] uio_in[4] uio_in[5] uio_in[6] uio_in[7]
+ VDPWR VGND
XXOR_4 XOR_4/XM6/G XOR_4/XM9/G VGND XOR_6/XM9/G XOR_4/XM9/S XOR
XXOR_5 XOR_5/XM6/G XOR_5/XM9/G VGND XOR_6/XM6/G VDPWR XOR
XVCO_0 ua[0] VCO_0/XM2/G XOR_4/XM9/S VGND VCO
XXOR_6 XOR_6/XM6/G XOR_6/XM9/G VGND ua[1] VDPWR XOR
XVCO_1 ua[0] VCO_1/XM2/G XOR_4/XM9/S VGND VCO
XVCO_2 ua[0] VCO_2/XM2/G XOR_4/XM9/S VGND VCO
XVCO_3 ua[0] VCO_3/XM2/G XOR_4/XM9/S VGND VCO
XVCO_4 ua[0] VCO_4/XM2/G VDPWR VGND VCO
XBUFFER_0 XOR_0/XM6/G XOR_4/XM9/S VCO_0/XM2/G VGND BUFFER
XVCO_5 ua[0] VCO_5/XM2/G VDPWR VGND VCO
XBUFFER_1 XOR_0/XM9/G XOR_4/XM9/S VCO_1/XM2/G VGND BUFFER
XVCO_6 ua[0] VCO_6/XM2/G VDPWR VGND VCO
XBUFFER_2 XOR_1/XM6/G XOR_4/XM9/S VCO_2/XM2/G VGND BUFFER
XVCO_7 ua[0] VCO_7/XM2/G VDPWR VGND VCO
XBUFFER_3 XOR_1/XM9/G XOR_4/XM9/S VCO_3/XM2/G VGND BUFFER
XBUFFER_4 XOR_2/XM9/G VDPWR VCO_4/XM2/G VGND BUFFER
XBUFFER_5 XOR_2/XM6/G VDPWR VCO_5/XM2/G VGND BUFFER
XBUFFER_6 XOR_3/XM9/G VDPWR VCO_6/XM2/G VGND BUFFER
XDFLIPFLOP_0 ua[1] VGND ua[3] ua[2] VDPWR DFLIPFLOP
XBUFFER_7 XOR_3/XM6/G VDPWR VCO_7/XM2/G VGND BUFFER
XXOR_0 XOR_0/XM6/G XOR_0/XM9/G VGND XOR_4/XM6/G XOR_4/XM9/S XOR
XXOR_1 XOR_1/XM6/G XOR_1/XM9/G VGND XOR_4/XM9/G XOR_4/XM9/S XOR
XXOR_2 XOR_2/XM6/G XOR_2/XM9/G VGND XOR_5/XM9/G VDPWR XOR
XXOR_3 XOR_3/XM6/G XOR_3/XM9/G VGND XOR_5/XM6/G VDPWR XOR
.ends
