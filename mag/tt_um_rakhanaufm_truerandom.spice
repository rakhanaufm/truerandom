* NGSPICE file created from tt_um_rakhanaufm_truerandom.ext - technology: sky130A

.subckt sky130_fd_pr__nfet_01v8_MH3LLV B D S G
X0 S G D B sky130_fd_pr__nfet_01v8 ad=0.29 pd=2.58 as=0.29 ps=2.58 w=1 l=0.15
C0 D G 0.02545f
C1 S G 0.02545f
C2 S D 0.16211f
C3 S B 0.1317f
C4 D B 0.1317f
C5 G B 0.32631f
.ends

.subckt sky130_fd_pr__pfet_01v8_A6MZLZ B D S G VSUBS
X0 S G D B sky130_fd_pr__pfet_01v8 ad=0.58 pd=4.58 as=0.58 ps=4.58 w=2 l=0.15
C0 S B 0.14266f
C1 G B 0.24043f
C2 S G 0.02934f
C3 D B 0.14266f
C4 D S 0.32105f
C5 D G 0.02934f
C6 S VSUBS 0.09023f
C7 D VSUBS 0.09023f
C8 G VSUBS 0.10256f
C9 B VSUBS 1.5811f
.ends

.subckt XOR XM6/S XM9/D XM9/S XM9/G XM7/G VSUBS
XXM1 VSUBS XM9/D VSUBS XM9/G sky130_fd_pr__nfet_01v8_MH3LLV
XXM2 XM9/D XM9/D VSUBS XM6/S VSUBS sky130_fd_pr__pfet_01v8_A6MZLZ
XXM3 XM9/S XM9/S XM6/S XM7/G VSUBS sky130_fd_pr__pfet_01v8_A6MZLZ
XXM4 XM9/G VSUBS XM9/G XM7/G VSUBS sky130_fd_pr__pfet_01v8_A6MZLZ
XXM5 VSUBS VSUBS XM9/G XM6/S sky130_fd_pr__nfet_01v8_MH3LLV
XXM6 VSUBS VSUBS XM6/S XM7/G sky130_fd_pr__nfet_01v8_MH3LLV
XXM7 VSUBS XM9/D VSUBS XM7/G sky130_fd_pr__nfet_01v8_MH3LLV
XXM9 XM9/S XM9/D XM9/S XM9/G VSUBS sky130_fd_pr__pfet_01v8_A6MZLZ
C0 XM7/G XM9/G 0.74297f
C1 XM9/S XM9/D 0.71068f
C2 XM9/D XM9/G 0.48712f
C3 XM7/G XM9/D 0.48539f
C4 XM6/S XM9/S 0.3071f
C5 XM6/S XM9/G 0.43654f
C6 XM9/S XM9/G 0.62056f
C7 XM6/S XM7/G 1.03102f
C8 XM6/S XM9/D 0.87865f
C9 XM7/G XM9/S 0.81306f
C10 XM9/D VSUBS 0.87072f
C11 XM9/G VSUBS 1.67803f
C12 XM9/S VSUBS 1.08419f
C13 XM7/G VSUBS 1.33223f
C14 XM6/S VSUBS 0.80388f
.ends

.subckt sky130_fd_pr__nfet_01v8_45YRG6 B D S G
X0 S G D B sky130_fd_pr__nfet_01v8 ad=0.145 pd=1.58 as=0.145 ps=1.58 w=0.5 l=0.15
C0 D S 0.08265f
C1 G S 0.02159f
C2 D G 0.02159f
C3 S B 0.08098f
C4 D B 0.08098f
C5 G B 0.32207f
.ends

.subckt sky130_fd_pr__nfet_01v8_7TC9PA B D S G
X0 S G D B sky130_fd_pr__nfet_01v8 ad=0.145 pd=1.58 as=0.145 ps=1.58 w=0.5 l=0.5
C0 D S 0.04621f
C1 G S 0.01008f
C2 D G 0.01008f
C3 S B 0.08856f
C4 D B 0.08856f
C5 G B 0.38424f
.ends

.subckt sky130_fd_pr__pfet_01v8_T4HHSR B D S G VSUBS
X0 S G D B sky130_fd_pr__pfet_01v8 ad=0.29 pd=2.58 as=0.29 ps=2.58 w=1 l=0.5
C0 G D 0.01627f
C1 B D 0.08523f
C2 G B 0.27949f
C3 S D 0.09063f
C4 S G 0.01627f
C5 S B 0.08523f
C6 S VSUBS 0.05583f
C7 D VSUBS 0.05583f
C8 G VSUBS 0.12371f
C9 B VSUBS 1.40666f
.ends

.subckt sky130_fd_pr__pfet_01v8_TMVPE9 B D S G VSUBS
X0 S G D B sky130_fd_pr__pfet_01v8 ad=0.29 pd=2.58 as=0.29 ps=2.58 w=1 l=0.15
C0 G D 0.02364f
C1 B D 0.08169f
C2 G B 0.23883f
C3 S D 0.16211f
C4 S G 0.02364f
C5 S B 0.08169f
C6 S VSUBS 0.04976f
C7 D VSUBS 0.04976f
C8 G VSUBS 0.10031f
C9 B VSUBS 1.2304f
.ends

.subckt VCO XM21/S XM9/D XM8/S XM3/D XM18/D XM20/D XM7/D XM8/D XM6/D XM9/G XM2/G XM22/D
+ XM16/D XM6/G VSUBS XM7/G XM6/S
XXM12 VSUBS XM6/D VSUBS XM9/G sky130_fd_pr__nfet_01v8_45YRG6
XXM14 XM6/S XM5/D XM8/S XM8/G VSUBS sky130_fd_pr__pfet_01v8_A6MZLZ
XXM13 VSUBS XM16/D XM2/G XM21/S sky130_fd_pr__nfet_01v8_MH3LLV
XXM15 VSUBS XM9/D XM7/G XM2/G sky130_fd_pr__nfet_01v8_MH3LLV
XXM16 VSUBS XM16/D VSUBS XM9/G sky130_fd_pr__nfet_01v8_7TC9PA
XXM17 XM6/S XM18/D XM2/G XM21/S VSUBS sky130_fd_pr__pfet_01v8_A6MZLZ
XXM18 XM6/S XM18/D XM6/S XM6/G VSUBS sky130_fd_pr__pfet_01v8_T4HHSR
XXM19 VSUBS XM20/D XM21/S XM8/S sky130_fd_pr__nfet_01v8_MH3LLV
XXM1 XM6/S XM4/D XM8/G XM7/G VSUBS sky130_fd_pr__pfet_01v8_A6MZLZ
XXM2 XM6/S XM3/D XM7/G XM2/G VSUBS sky130_fd_pr__pfet_01v8_A6MZLZ
XXM3 XM6/S XM3/D XM6/S XM6/G VSUBS sky130_fd_pr__pfet_01v8_T4HHSR
XXM4 XM6/S XM4/D XM6/S XM6/G VSUBS sky130_fd_pr__pfet_01v8_T4HHSR
XXM5 XM6/S XM5/D XM6/S XM6/G VSUBS sky130_fd_pr__pfet_01v8_T4HHSR
XXM6 XM6/S XM6/D XM6/S XM6/G VSUBS sky130_fd_pr__pfet_01v8_TMVPE9
XXM7 VSUBS XM7/D XM8/G XM7/G sky130_fd_pr__nfet_01v8_MH3LLV
XXM8 VSUBS XM8/D XM8/S XM8/G sky130_fd_pr__nfet_01v8_MH3LLV
XXM9 VSUBS XM9/D VSUBS XM9/G sky130_fd_pr__nfet_01v8_7TC9PA
XXM20 VSUBS XM20/D VSUBS XM9/G sky130_fd_pr__nfet_01v8_7TC9PA
XXM21 XM6/S XM22/D XM21/S XM8/S VSUBS sky130_fd_pr__pfet_01v8_A6MZLZ
XXM10 VSUBS XM7/D VSUBS XM9/G sky130_fd_pr__nfet_01v8_7TC9PA
XXM22 XM6/S XM22/D XM6/S XM6/G VSUBS sky130_fd_pr__pfet_01v8_T4HHSR
XXM11 VSUBS XM8/D VSUBS XM9/G sky130_fd_pr__nfet_01v8_7TC9PA
C0 XM8/S XM20/D 0.25836f
C1 XM9/G XM7/D 0.17428f
C2 XM2/G XM4/D 0.01306f
C3 XM6/G XM22/D 0.23027f
C4 XM22/D XM8/S 0.24638f
C5 XM6/G XM9/D 0
C6 XM5/D XM4/D 0.06868f
C7 XM6/G XM21/S 0.00221f
C8 XM9/G XM3/D 0
C9 XM9/G XM7/G 0.0046f
C10 XM6/S XM9/G 0.00237f
C11 XM9/G XM8/D 0.17426f
C12 XM8/G XM2/G 0.25568f
C13 XM21/S XM8/S 0.11394f
C14 XM8/G XM5/D 0.24638f
C15 XM6/G XM7/D 0
C16 XM21/S XM20/D 0.00592f
C17 XM9/G XM18/D 0
C18 XM2/G XM16/D 0.01855f
C19 XM6/D XM4/D 0
C20 XM6/G XM3/D 0.1412f
C21 XM6/G XM7/G 0.00221f
C22 XM22/D XM21/S 0.01681f
C23 XM6/G XM6/S 2.48596f
C24 XM6/G XM8/D 0
C25 XM8/G XM6/D 0
C26 XM6/S XM8/S 0.442f
C27 XM8/D XM8/S 0.00578f
C28 XM2/G XM5/D 0.01222f
C29 XM9/G XM4/D 0
C30 XM8/D XM20/D 0.04232f
C31 XM6/G XM18/D 0.22945f
C32 XM9/D XM7/D 0.04232f
C33 XM8/S XM18/D 0
C34 XM8/G XM9/G 0.0046f
C35 XM6/S XM22/D 0.4097f
C36 XM2/G XM6/D 0.01399f
C37 XM9/D XM7/G 0.00592f
C38 XM6/S XM21/S 0.44123f
C39 XM6/G XM4/D 0.23027f
C40 XM9/G XM16/D 0.17017f
C41 XM22/D XM18/D 0.06868f
C42 XM9/G XM2/G 0.01882f
C43 XM6/G XM8/G 0.00221f
C44 XM7/G XM7/D 0.25836f
C45 XM8/D XM7/D 0.04232f
C46 XM21/S XM18/D 0.24638f
C47 XM9/G XM5/D 0
C48 XM8/G XM8/S 0.11428f
C49 XM7/G XM3/D 0.0168f
C50 XM6/S XM3/D 0.42599f
C51 XM6/S XM7/G 0.44307f
C52 XM8/D XM7/G 0
C53 XM6/G XM16/D 0
C54 XM8/G XM20/D 0
C55 XM8/S XM16/D 0
C56 XM6/G XM2/G 0.00694f
C57 XM9/G XM6/D 0.17867f
C58 XM22/D XM8/G 0
C59 XM2/G XM8/S 0.25568f
C60 XM6/G XM5/D 0.23027f
C61 XM6/S XM18/D 0.40662f
C62 XM16/D XM20/D 0.04232f
C63 XM8/S XM5/D 0.01667f
C64 XM2/G XM20/D 0.01417f
C65 XM8/G XM7/D 0.00592f
C66 XM3/D XM4/D 0.06868f
C67 XM7/G XM4/D 0.24638f
C68 XM21/S XM16/D 0.25623f
C69 XM6/S XM4/D 0.40971f
C70 XM22/D XM2/G 0.01222f
C71 XM6/G XM6/D 0.20221f
C72 XM2/G XM9/D 0.27306f
C73 XM22/D XM5/D 0.06868f
C74 XM2/G XM21/S 0.34913f
C75 XM8/G XM7/G 0.11394f
C76 XM6/S XM8/G 0.44305f
C77 XM8/G XM8/D 0.25836f
C78 XM6/G XM9/G 0
C79 XM2/G XM7/D 0.01486f
C80 XM9/G XM8/S 0.0046f
C81 XM9/D XM6/D 0.02837f
C82 XM2/G XM3/D 0.25767f
C83 XM2/G XM7/G 0.36969f
C84 XM6/S XM2/G 0.68116f
C85 XM8/D XM2/G 0.01417f
C86 XM9/G XM20/D 0.17426f
C87 XM7/G XM5/D 0
C88 XM6/S XM5/D 0.40845f
C89 XM22/D XM9/G 0
C90 XM8/G XM4/D 0.01681f
C91 XM7/D XM6/D 0
C92 XM6/G XM8/S 0.00221f
C93 XM9/G XM9/D 0.19013f
C94 XM2/G XM18/D 0.02845f
C95 XM9/G XM21/S 0.0046f
C96 XM6/D XM3/D 0.04389f
C97 XM7/G XM6/D 0.00159f
C98 XM6/S XM6/D 0.20833f
C99 XM6/G XM20/D 0
C100 XM22/D VSUBS -0.04673f
C101 XM9/D VSUBS 0.20537f
C102 XM9/G VSUBS 3.76576f
C103 XM8/S VSUBS 0.43324f
C104 XM8/D VSUBS 0.2103f
C105 XM8/G VSUBS 0.43556f
C106 XM7/D VSUBS 0.21068f
C107 XM6/G VSUBS 0.82687f
C108 XM3/D VSUBS 0
C109 XM6/S VSUBS 0.26986f
C110 XM4/D VSUBS -0.04673f
C111 XM21/S VSUBS 0.45777f
C112 XM20/D VSUBS 0.21066f
C113 XM18/D VSUBS 0.02164f
C114 XM7/G VSUBS 0.43558f
C115 XM2/G VSUBS 1.54253f
C116 XM16/D VSUBS 0.26714f
C117 XM5/D VSUBS -0.04673f
C118 XM6/D VSUBS 0.53616f
.ends

.subckt sky130_fd_pr__pfet_01v8_FNQE4J B D S G VSUBS
X0 S G D B sky130_fd_pr__pfet_01v8 ad=1.16 pd=8.58 as=1.16 ps=8.58 w=4 l=0.15
C0 G S 0.03853f
C1 B G 0.24144f
C2 D G 0.03853f
C3 B S 0.26461f
C4 D S 0.63892f
C5 B D 0.26461f
C6 S VSUBS 0.17118f
C7 D VSUBS 0.17118f
C8 G VSUBS 0.10481f
C9 B VSUBS 2.28132f
.ends

.subckt sky130_fd_pr__nfet_01v8_33NS5F B D S G
X0 S G D B sky130_fd_pr__nfet_01v8 ad=0.58 pd=4.58 as=0.58 ps=4.58 w=2 l=0.15
C0 G D 0.03122f
C1 S D 0.32105f
C2 G S 0.03122f
C3 S B 0.23315f
C4 D B 0.23315f
C5 G B 0.33052f
.ends

.subckt sky130_fd_pr__pfet_01v8_XAKWQW B D S G VSUBS
X0 S G D B sky130_fd_pr__pfet_01v8 ad=4.64 pd=32.58 as=4.64 ps=32.58 w=16 l=0.15
C0 G S 0.08675f
C1 B G 0.24198f
C2 D G 0.08675f
C3 B S 0.99631f
C4 D S 2.54614f
C5 B D 0.99631f
C6 S VSUBS 0.65688f
C7 D VSUBS 0.65688f
C8 G VSUBS 0.1126f
C9 B VSUBS 6.48306f
.ends

.subckt sky130_fd_pr__nfet_01v8_77S659 B D S G
X0 S G D B sky130_fd_pr__nfet_01v8 ad=2.32 pd=16.58 as=2.32 ps=16.58 w=8 l=0.15
C0 G D 0.05702f
C1 S D 1.27466f
C2 G S 0.05702f
C3 S B 0.84185f
C4 D B 0.84185f
C5 G B 0.34243f
.ends

.subckt sky130_fd_pr__pfet_01v8_U2FPYB B D S G VSUBS
X0 S G D B sky130_fd_pr__pfet_01v8 ad=2.32 pd=16.58 as=2.32 ps=16.58 w=8 l=0.15
C0 G S 0.0551f
C1 B G 0.24198f
C2 D G 0.0551f
C3 B S 0.50851f
C4 D S 1.27466f
C5 B D 0.50851f
C6 S VSUBS 0.33308f
C7 D VSUBS 0.33308f
C8 G VSUBS 0.1126f
C9 B VSUBS 3.68698f
.ends

.subckt sky130_fd_pr__nfet_01v8_WK9H77 B D S G
X0 S G D B sky130_fd_pr__nfet_01v8 ad=1.16 pd=8.58 as=1.16 ps=8.58 w=4 l=0.15
C0 G D 0.04044f
C1 S D 0.63892f
C2 G S 0.04044f
C3 S B 0.43605f
C4 D B 0.43605f
C5 G B 0.33399f
.ends

.subckt BUFFER XM6/S XM7/D XM8/G XM5/S XM8/S XM5/G VSUBS
XXM1 XM7/D XM7/D XM8/G XM5/S VSUBS sky130_fd_pr__pfet_01v8_FNQE4J
XXM2 VSUBS VSUBS XM8/G XM5/S sky130_fd_pr__nfet_01v8_33NS5F
XXM3 VSUBS VSUBS XM5/S XM5/G sky130_fd_pr__nfet_01v8_MH3LLV
XXM4 XM7/D XM7/D XM6/S XM8/S VSUBS sky130_fd_pr__pfet_01v8_XAKWQW
XXM5 XM7/D XM7/D XM5/S XM5/G VSUBS sky130_fd_pr__pfet_01v8_A6MZLZ
XXM6 VSUBS VSUBS XM6/S XM8/S sky130_fd_pr__nfet_01v8_77S659
XXM7 XM7/D XM7/D XM8/S XM8/G VSUBS sky130_fd_pr__pfet_01v8_U2FPYB
XXM8 VSUBS VSUBS XM8/S XM8/G sky130_fd_pr__nfet_01v8_WK9H77
C0 XM6/S XM8/S 0.09336f
C1 XM6/S XM5/S 0
C2 XM6/S XM8/G 0
C3 XM6/S XM7/D 0.24058f
C4 XM5/S XM8/S 0
C5 XM5/G XM8/S 0
C6 XM8/G XM8/S 0.11695f
C7 XM5/G XM5/S 0.11242f
C8 XM5/S XM8/G 0.11243f
C9 XM7/D XM8/S 2.89505f
C10 XM5/G XM8/G 0
C11 XM5/S XM7/D 1.13378f
C12 XM5/G XM7/D 0.59779f
C13 XM8/G XM7/D 1.62442f
C14 XM8/S VSUBS 1.83854f
C15 XM8/G VSUBS 1.17621f
C16 XM7/D VSUBS 0.68083f
C17 XM6/S VSUBS 0.31775f
C18 XM5/S VSUBS 0.85325f
C19 XM5/G VSUBS 0.6338f
.ends

.subckt sky130_fd_pr__pfet_01v8_LE4Y8H B D S G VSUBS
X0 S G D B sky130_fd_pr__pfet_01v8 ad=1.74 pd=12.58 as=1.74 ps=12.58 w=6 l=0.15
C0 D G 0.04694f
C1 D S 0.95679f
C2 B G 0.24183f
C3 B S 0.38656f
C4 S G 0.04694f
C5 B D 0.38656f
C6 S VSUBS 0.25213f
C7 D VSUBS 0.25213f
C8 G VSUBS 0.10585f
C9 B VSUBS 2.98092f
.ends

.subckt sky130_fd_pr__nfet_01v8_GM8MVP B D S G
X0 S G D B sky130_fd_pr__nfet_01v8 ad=0.87 pd=6.58 as=0.87 ps=6.58 w=3 l=0.15
C0 S D 0.47998f
C1 G D 0.03602f
C2 G S 0.03602f
C3 S B 0.3346f
C4 D B 0.3346f
C5 G B 0.33268f
.ends

.subckt DFLIPFLOP XM7/G XM2/S XM4/D XM5/G XM9/G XM8/D XM9/S XM8/G XM7/D VSUBS XM6/D
XXM1 XM6/D XM7/D XM2/S XM8/G VSUBS sky130_fd_pr__pfet_01v8_LE4Y8H
XXM2 XM6/D XM6/D XM2/S XM7/G VSUBS sky130_fd_pr__pfet_01v8_LE4Y8H
XXM3 XM6/D XM6/D XM5/G XM8/G VSUBS sky130_fd_pr__pfet_01v8_LE4Y8H
XXM4 VSUBS XM4/D XM5/G XM7/D sky130_fd_pr__nfet_01v8_GM8MVP
XXM5 XM6/D XM6/D XM9/G XM5/G VSUBS sky130_fd_pr__pfet_01v8_LE4Y8H
XXM6 XM6/D XM6/D XM9/S XM9/G VSUBS sky130_fd_pr__pfet_01v8_LE4Y8H
XXM7 VSUBS XM7/D VSUBS XM7/G sky130_fd_pr__nfet_01v8_GM8MVP
XXM8 VSUBS XM8/D XM9/G XM8/G sky130_fd_pr__nfet_01v8_GM8MVP
XXM9 VSUBS VSUBS XM9/S XM9/G sky130_fd_pr__nfet_01v8_GM8MVP
XXM10 VSUBS XM4/D VSUBS XM8/G sky130_fd_pr__nfet_01v8_GM8MVP
XXM11 VSUBS XM8/D VSUBS XM5/G sky130_fd_pr__nfet_01v8_GM8MVP
C0 XM7/G XM4/D 0.00679f
C1 XM7/D XM9/G 0
C2 XM8/D XM7/D 0
C3 XM7/D XM8/G 1.08571f
C4 XM7/G XM6/D 1.58115f
C5 XM7/D XM5/G 0.05079f
C6 XM7/G XM9/G 0.00199f
C7 XM8/D XM7/G 0.0022f
C8 XM6/D XM4/D 0
C9 XM7/G XM8/G 0.34614f
C10 XM7/G XM5/G 0.02289f
C11 XM9/G XM4/D 0
C12 XM8/D XM4/D 0.06475f
C13 XM7/D XM2/S 0.15974f
C14 XM8/G XM4/D 0.5728f
C15 XM6/D XM9/G 1.34322f
C16 XM8/D XM6/D 0
C17 XM5/G XM4/D 0.00753f
C18 XM6/D XM8/G 1.71631f
C19 XM6/D XM5/G 1.32717f
C20 XM7/G XM2/S 0.13909f
C21 XM8/D XM9/G 0.0028f
C22 XM8/G XM9/G 0.04669f
C23 XM8/D XM8/G 0.3395f
C24 XM5/G XM9/G 0.13199f
C25 XM8/D XM5/G 0.35427f
C26 XM5/G XM8/G 0.61139f
C27 XM7/G XM7/D 0.60466f
C28 XM6/D XM2/S 0.66409f
C29 XM6/D XM9/S 0.28749f
C30 XM7/D XM4/D 0.38137f
C31 XM2/S XM8/G 0.47862f
C32 XM9/S XM9/G 0.17916f
C33 XM6/D XM7/D 0.11134f
C34 XM5/G XM2/S 0.05551f
C35 XM9/S XM8/G 0
C36 XM9/S VSUBS 0.51539f
C37 XM9/G VSUBS 1.15998f
C38 XM8/D VSUBS 0.07816f
C39 XM7/G VSUBS 2.05931f
C40 XM5/G VSUBS 1.42907f
C41 XM4/D VSUBS -0.04291f
C42 XM2/S VSUBS -0.07867f
C43 XM7/D VSUBS 0.42959f
C44 XM8/G VSUBS 2.25654f
C45 XM6/D VSUBS -0.65207f
.ends

.subckt tt_um_rakhanaufm_truerandom clk ena rst_n ua[0] ua[2] ua[3] ua[4] ua[5] ua[6]
+ ua[7] ui_in[0] ui_in[1] ui_in[2] ui_in[3] ui_in[4] ui_in[5] ui_in[6] ui_in[7] uio_in[0]
+ uio_in[1] uio_in[2] uio_in[3] uio_in[4] uio_in[5] uio_in[6] uio_in[7] VDPWR VGND
XXOR_4 XOR_4/XM6/S XOR_4/XM9/D XOR_4/XM9/S VGND VGND VGND XOR
XXOR_5 XOR_5/XM6/S XOR_5/XM9/D VDPWR VGND VGND VGND XOR
XVCO_0 VCO_0/XM21/S VCO_0/XM9/D VCO_0/XM8/S VCO_0/XM3/D VCO_0/XM18/D VCO_0/XM20/D
+ VCO_0/XM7/D VCO_0/XM8/D VCO_0/XM6/D ua[0] VCO_0/XM2/G VCO_0/XM22/D VCO_0/XM16/D
+ VCO_0/XM6/G VGND VCO_0/XM7/G XOR_4/XM9/S VCO
XXOR_6 XOR_6/XM6/S XOR_6/XM9/D VDPWR VGND VGND VGND XOR
XVCO_1 VCO_1/XM21/S VCO_1/XM9/D VCO_1/XM8/S VCO_1/XM3/D VCO_1/XM18/D VCO_1/XM20/D
+ VCO_1/XM7/D VCO_1/XM8/D VCO_1/XM6/D ua[0] VCO_1/XM2/G VCO_1/XM22/D VCO_1/XM16/D
+ VCO_1/XM6/G VGND VCO_1/XM7/G XOR_4/XM9/S VCO
XVCO_2 VCO_2/XM21/S VCO_2/XM9/D VCO_2/XM8/S VCO_2/XM3/D VCO_2/XM18/D VCO_2/XM20/D
+ VCO_2/XM7/D VCO_2/XM8/D VCO_2/XM6/D ua[0] VCO_2/XM2/G VCO_2/XM22/D VCO_2/XM16/D
+ VCO_2/XM6/G VGND VCO_2/XM7/G XOR_4/XM9/S VCO
XVCO_3 VCO_3/XM21/S VCO_3/XM9/D VCO_3/XM8/S VCO_3/XM3/D VCO_3/XM18/D VCO_3/XM20/D
+ VCO_3/XM7/D VCO_3/XM8/D VCO_3/XM6/D ua[0] VCO_3/XM2/G VCO_3/XM22/D VCO_3/XM16/D
+ VCO_3/XM6/G VGND VCO_3/XM7/G XOR_4/XM9/S VCO
XVCO_4 VCO_4/XM21/S VCO_4/XM9/D VCO_4/XM8/S VCO_4/XM3/D VCO_4/XM18/D VCO_4/XM20/D
+ VCO_4/XM7/D VCO_4/XM8/D VCO_4/XM6/D ua[0] VCO_4/XM2/G VCO_4/XM22/D VCO_4/XM16/D
+ VCO_4/XM6/G VGND VCO_4/XM7/G VDPWR VCO
XBUFFER_0 XOR_0/XM7/G XOR_4/XM9/S BUFFER_0/XM8/G BUFFER_0/XM5/S BUFFER_0/XM8/S VCO_0/XM2/G
+ VGND BUFFER
XVCO_5 VCO_5/XM21/S VCO_5/XM9/D VCO_5/XM8/S VCO_5/XM3/D VCO_5/XM18/D VCO_5/XM20/D
+ VCO_5/XM7/D VCO_5/XM8/D VCO_5/XM6/D ua[0] VCO_5/XM2/G VCO_5/XM22/D VCO_5/XM16/D
+ VCO_5/XM6/G VGND VCO_5/XM7/G VDPWR VCO
XBUFFER_1 XOR_0/XM9/G XOR_4/XM9/S BUFFER_1/XM8/G BUFFER_1/XM5/S BUFFER_1/XM8/S VCO_1/XM2/G
+ VGND BUFFER
XVCO_6 VCO_6/XM21/S VCO_6/XM9/D VCO_6/XM8/S VCO_6/XM3/D VCO_6/XM18/D VCO_6/XM20/D
+ VCO_6/XM7/D VCO_6/XM8/D VCO_6/XM6/D ua[0] VCO_6/XM2/G VCO_6/XM22/D VCO_6/XM16/D
+ VCO_6/XM6/G VGND VCO_6/XM7/G VDPWR VCO
XBUFFER_2 XOR_1/XM7/G XOR_4/XM9/S BUFFER_2/XM8/G BUFFER_2/XM5/S BUFFER_2/XM8/S VCO_2/XM2/G
+ VGND BUFFER
XVCO_7 VCO_7/XM21/S VCO_7/XM9/D VCO_7/XM8/S VCO_7/XM3/D VCO_7/XM18/D VCO_7/XM20/D
+ VCO_7/XM7/D VCO_7/XM8/D VCO_7/XM6/D ua[0] VCO_7/XM2/G VCO_7/XM22/D VCO_7/XM16/D
+ VCO_7/XM6/G VGND VCO_7/XM7/G VDPWR VCO
XBUFFER_3 XOR_1/XM9/G XOR_4/XM9/S BUFFER_3/XM8/G BUFFER_3/XM5/S BUFFER_3/XM8/S VCO_3/XM2/G
+ VGND BUFFER
XBUFFER_4 XOR_2/XM9/G BUFFER_4/XM7/D BUFFER_4/XM8/G BUFFER_4/XM5/S BUFFER_4/XM8/S
+ VCO_4/XM2/G VGND BUFFER
XBUFFER_5 XOR_2/XM7/G XOR_2/XM9/S BUFFER_5/XM8/G BUFFER_5/XM5/S BUFFER_5/XM8/S VCO_5/XM2/G
+ VGND BUFFER
XBUFFER_6 XOR_3/XM9/G VDPWR BUFFER_6/XM8/G BUFFER_6/XM5/S BUFFER_6/XM8/S VCO_6/XM2/G
+ VGND BUFFER
XDFLIPFLOP_0 VGND DFLIPFLOP_0/XM2/S DFLIPFLOP_0/XM4/D DFLIPFLOP_0/XM5/G DFLIPFLOP_0/XM9/G
+ DFLIPFLOP_0/XM8/D ua[2] ua[3] DFLIPFLOP_0/XM7/D VGND VDPWR DFLIPFLOP
XBUFFER_7 XOR_3/XM7/G VDPWR BUFFER_7/XM8/G BUFFER_7/XM5/S BUFFER_7/XM8/S VCO_7/XM2/G
+ VGND BUFFER
XXOR_0 XOR_0/XM6/S XOR_0/XM9/D XOR_4/XM9/S XOR_0/XM9/G XOR_0/XM7/G VGND XOR
XXOR_1 XOR_1/XM6/S XOR_1/XM9/D XOR_4/XM9/S XOR_1/XM9/G XOR_1/XM7/G VGND XOR
XXOR_2 XOR_2/XM6/S XOR_2/XM9/D XOR_2/XM9/S XOR_2/XM9/G XOR_2/XM7/G VGND XOR
XXOR_3 XOR_3/XM6/S XOR_3/XM9/D VDPWR XOR_3/XM9/G XOR_3/XM7/G VGND XOR
C0 XOR_3/XM7/G XOR_3/XM6/S -0
C1 VCO_2/XM18/D VCO_2/XM21/S 0
C2 VCO_2/XM6/G XOR_4/XM9/S 0.01358f
C3 BUFFER_5/XM5/S VCO_5/XM2/G 0
C4 VCO_5/XM2/G VCO_5/XM16/D 0
C5 VCO_3/XM2/G ua[0] 0.02643f
C6 ua[0] VCO_7/XM16/D -0
C7 BUFFER_6/XM8/S BUFFER_7/XM8/S 0.00209f
C8 VCO_0/XM2/G VCO_0/XM18/D 0
C9 BUFFER_4/XM7/D VCO_4/XM6/G 0.00217f
C10 ua[0] VCO_4/XM6/G 0.0486f
C11 BUFFER_1/XM5/S VCO_1/XM2/G 0
C12 VDPWR VCO_6/XM3/D 0.01742f
C13 VCO_7/XM6/D VDPWR 0.124f
C14 BUFFER_7/XM8/G VCO_7/XM18/D 0
C15 XOR_1/XM7/G BUFFER_2/XM8/G 0
C16 ua[0] VCO_5/XM6/D 0.00126f
C17 VCO_4/XM2/G BUFFER_4/XM7/D 0.00105f
C18 VCO_1/XM6/G ua[0] 0.04847f
C19 VCO_3/XM2/G VCO_3/XM18/D 0
C20 VCO_4/XM2/G ua[0] 0.02647f
C21 XOR_4/XM9/S BUFFER_1/XM8/S 0.00353f
C22 uio_in[3] uio_in[2] 0.03102f
C23 VCO_5/XM6/G XOR_2/XM9/S 0.00217f
C24 VCO_2/XM16/D BUFFER_2/XM5/S 0
C25 VDPWR VCO_6/XM6/D 0.1441f
C26 XOR_1/XM9/G XOR_1/XM9/D 0
C27 VDPWR VCO_7/XM9/D 0.01053f
C28 VCO_7/XM2/G BUFFER_7/XM5/S 0
C29 VCO_4/XM2/G VCO_4/XM16/D 0
C30 XOR_2/XM9/G BUFFER_4/XM8/S 0
C31 ua[0] VCO_6/XM16/D -0
C32 BUFFER_3/XM5/S VCO_3/XM21/S 0
C33 VCO_3/XM2/G XOR_4/XM9/S 0.06178f
C34 XOR_3/XM9/G BUFFER_6/XM8/G 0
C35 XOR_4/XM9/S VCO_2/XM3/D 0.01767f
C36 VCO_4/XM2/G VCO_4/XM21/S 0.02355f
C37 XOR_1/XM9/G XOR_1/XM7/G 0.0179f
C38 DFLIPFLOP_0/XM5/G ua[3] 0.05229f
C39 VCO_4/XM2/G BUFFER_4/XM5/S 0
C40 BUFFER_2/XM8/S BUFFER_1/XM8/S 0.00217f
C41 VCO_5/XM21/S VCO_5/XM2/G 0.02355f
C42 XOR_1/XM9/G BUFFER_3/XM8/G 0
C43 VCO_0/XM2/G BUFFER_0/XM8/G 0
C44 BUFFER_3/XM8/S XOR_1/XM9/D 0
C45 XOR_2/XM9/G BUFFER_4/XM8/G 0
C46 VCO_1/XM6/G XOR_4/XM9/S 0.01358f
C47 VCO_3/XM2/G VCO_3/XM16/D 0
C48 VDPWR XOR_3/XM7/G 0.21267f
C49 BUFFER_1/XM8/G XOR_0/XM9/G 0
C50 VCO_6/XM2/G VCO_6/XM16/D 0
C51 VDPWR VCO_5/XM9/D 0.01053f
C52 VCO_4/XM2/G VCO_4/XM18/D 0
C53 XOR_2/XM7/G BUFFER_5/XM8/S 0
C54 XOR_5/XM6/S XOR_5/XM9/D 0
C55 XOR_4/XM9/S BUFFER_0/XM8/S 0.00896f
C56 VCO_2/XM2/G BUFFER_2/XM8/G 0
C57 BUFFER_5/XM5/S VCO_5/XM16/D 0
C58 BUFFER_3/XM5/S VCO_3/XM18/D 0
C59 XOR_4/XM9/S VCO_0/XM2/G 0.06317f
C60 VCO_6/XM2/G VCO_6/XM18/D 0
C61 DFLIPFLOP_0/XM8/D ua[3] 0.02129f
C62 XOR_4/XM9/S BUFFER_2/XM8/G 0
C63 ua[0] VCO_5/XM2/G 0.02647f
C64 XOR_6/XM6/S VDPWR 0.02302f
C65 VCO_6/XM2/G VCO_6/XM21/S 0.02355f
C66 VDPWR VCO_4/XM6/G 0.01073f
C67 VDPWR XOR_2/XM9/S 0.12237f
C68 VDPWR VCO_5/XM6/D 0.1441f
C69 BUFFER_5/XM8/S XOR_2/XM9/S 0.00156f
C70 VCO_4/XM2/G VDPWR 0.01659f
C71 BUFFER_0/XM5/S VCO_0/XM21/S 0
C72 XOR_4/XM9/S BUFFER_3/XM5/S 0
C73 uio_in[1] uio_in[0] 0.03102f
C74 VCO_4/XM20/D VDPWR 0.002f
C75 BUFFER_0/XM8/S XOR_0/XM7/G 0.00496f
C76 XOR_4/XM9/S XOR_0/XM9/D 0.08427f
C77 VCO_7/XM18/D BUFFER_7/XM5/S 0
C78 ua[0] VCO_3/XM6/G 0.04847f
C79 BUFFER_0/XM8/S VDPWR 0.00341f
C80 XOR_1/XM9/G XOR_4/XM9/S 0.07926f
C81 ua[0] VCO_7/XM7/G 0.00105f
C82 BUFFER_3/XM5/S VCO_3/XM16/D 0
C83 VCO_3/XM3/D XOR_4/XM9/S 0.01767f
C84 VCO_4/XM16/D BUFFER_4/XM8/G 0
C85 VCO_5/XM18/D XOR_2/XM9/S 0.04454f
C86 VCO_5/XM21/S BUFFER_5/XM5/S 0
C87 VCO_6/XM22/D VDPWR 0
C88 uio_in[3] uio_in[4] 0.03102f
C89 VCO_0/XM16/D BUFFER_0/XM5/S 0
C90 VDPWR BUFFER_7/XM5/S 0
C91 VCO_7/XM2/G VCO_7/XM21/S 0.02355f
C92 VDPWR VCO_6/XM18/D 0.05098f
C93 VCO_2/XM2/G BUFFER_2/XM5/S 0
C94 VCO_2/XM18/D BUFFER_2/XM8/G 0
C95 VDPWR VCO_6/XM21/S 0.00308f
C96 XOR_4/XM9/S XOR_0/XM9/G 0.05935f
C97 XOR_3/XM9/D XOR_3/XM9/G 0
C98 BUFFER_3/XM8/S XOR_4/XM9/S 0
C99 XOR_1/XM9/G BUFFER_2/XM8/S 0.00346f
C100 XOR_4/XM9/S BUFFER_2/XM5/S 0
C101 XOR_0/XM7/G XOR_0/XM9/D 0
C102 BUFFER_7/XM8/G XOR_3/XM7/G 0
C103 uio_in[6] uio_in[5] 0.03102f
C104 XOR_4/XM9/S VCO_3/XM6/G 0.01358f
C105 BUFFER_6/XM5/S VCO_6/XM16/D 0
C106 BUFFER_4/XM8/G VCO_4/XM18/D 0
C107 ua[0] VCO_5/XM16/D -0
C108 XOR_1/XM9/D XOR_1/XM7/G 0
C109 ui_in[1] ui_in[2] 0.03102f
C110 VDPWR VCO_5/XM2/G 0.01644f
C111 VDPWR BUFFER_4/XM8/S 0.00346f
C112 BUFFER_3/XM8/S BUFFER_2/XM8/S 0.00217f
C113 VCO_6/XM6/G VCO_6/XM18/D 0
C114 BUFFER_5/XM8/S BUFFER_4/XM8/S 0.00217f
C115 ua[2] DFLIPFLOP_0/XM9/G 0.00568f
C116 BUFFER_7/XM8/G VCO_7/XM16/D 0
C117 XOR_0/XM7/G XOR_0/XM9/G 0.01558f
C118 BUFFER_6/XM8/S BUFFER_5/XM8/S 0.00217f
C119 BUFFER_6/XM5/S VCO_6/XM18/D 0
C120 BUFFER_6/XM5/S VCO_6/XM21/S 0
C121 VCO_0/XM2/G VCO_0/XM21/S 0.02355f
C122 ua[0] VCO_6/XM9/D 0
C123 VCO_5/XM18/D BUFFER_5/XM8/G 0
C124 XOR_2/XM9/G BUFFER_4/XM7/D 0.04755f
C125 VDPWR BUFFER_4/XM8/G 0
C126 VCO_2/XM16/D VCO_2/XM2/G 0
C127 VCO_2/XM18/D BUFFER_2/XM5/S 0
C128 VCO_6/XM2/G BUFFER_6/XM8/G 0
C129 VCO_5/XM18/D VCO_5/XM2/G 0
C130 VCO_0/XM22/D XOR_4/XM9/S -0
C131 VCO_1/XM2/G VCO_1/XM16/D 0
C132 XOR_3/XM9/G VDPWR 0.05106f
C133 VCO_1/XM18/D BUFFER_1/XM8/G 0
C134 ui_in[3] ui_in[2] 0.03102f
C135 XOR_4/XM9/S XOR_0/XM6/S 0.07382f
C136 XOR_2/XM7/G XOR_2/XM9/S 0.1699f
C137 VCO_0/XM2/G VCO_0/XM16/D 0
C138 BUFFER_1/XM5/S VCO_1/XM16/D 0
C139 ua[0] VCO_4/XM9/D 0
C140 VCO_0/XM2/G BUFFER_0/XM5/S 0
C141 clk ena 0.03102f
C142 VCO_0/XM18/D BUFFER_0/XM8/G 0
C143 VCO_7/XM2/G ua[0] 0.01438f
C144 BUFFER_2/XM5/S VCO_2/XM21/S 0
C145 VCO_3/XM18/D BUFFER_3/XM8/G 0
C146 BUFFER_0/XM8/S BUFFER_1/XM8/S 0.00209f
C147 XOR_1/XM9/D XOR_4/XM9/S 0
C148 VCO_1/XM21/S VCO_1/XM18/D -0
C149 VDPWR VCO_4/XM3/D 0.01742f
C150 VDPWR VCO_7/XM21/S 0.00308f
C151 VCO_0/XM9/D ua[0] 0
C152 VCO_3/XM18/D VCO_3/XM21/S 0
C153 VDPWR BUFFER_7/XM8/S 0.00302f
C154 XOR_2/XM9/D XOR_2/XM9/G 0
C155 ua[2] ua[0] 0.06348f
C156 VDPWR BUFFER_5/XM5/S 0
C157 ui_in[1] ui_in[0] 0.03102f
C158 ua[0] VCO_3/XM6/D 0.00491f
C159 XOR_0/XM7/G XOR_0/XM6/S -0
C160 XOR_4/XM9/S VCO_0/XM18/D 0.05098f
C161 XOR_1/XM7/G XOR_4/XM9/S 0.2765f
C162 ua[0] VCO_5/XM6/G 0.0486f
C163 VCO_4/XM16/D ua[0] 0
C164 XOR_4/XM9/S VCO_3/XM21/S 0.00308f
C165 ui_in[5] ui_in[4] 0.03102f
C166 VDPWR VCO_6/XM9/D 0.01053f
C167 ua[0] VCO_2/XM9/D 0
C168 VCO_4/XM21/S BUFFER_4/XM7/D 0.00308f
C169 VCO_5/XM18/D BUFFER_5/XM5/S 0
C170 VCO_2/XM6/D ua[0] 0.00125f
C171 XOR_2/XM9/G VDPWR 0.00223f
C172 VCO_7/XM16/D BUFFER_7/XM5/S 0
C173 BUFFER_4/XM7/D BUFFER_4/XM5/S -0
C174 ua[0] VCO_2/XM2/G 0.02643f
C175 VCO_6/XM2/G ua[0] 0.02647f
C176 VCO_0/XM9/D XOR_4/XM9/S 0.01069f
C177 XOR_2/XM7/G BUFFER_5/XM8/G 0
C178 XOR_1/XM7/G BUFFER_2/XM8/S 0
C179 VCO_1/XM21/S XOR_4/XM9/S 0.00308f
C180 ua[0] VCO_1/XM6/D 0.00125f
C181 VCO_0/XM6/G XOR_4/XM9/S 0.01227f
C182 VCO_1/XM18/D XOR_4/XM9/S 0.05098f
C183 VCO_3/XM2/G BUFFER_3/XM5/S 0
C184 VCO_7/XM2/G VCO_7/XM18/D 0
C185 VCO_1/XM9/D ua[0] 0
C186 XOR_4/XM9/S VCO_3/XM6/D 0.06766f
C187 XOR_4/XM9/S ua[0] 5.11352f
C188 VCO_4/XM16/D BUFFER_4/XM5/S 0
C189 BUFFER_4/XM7/D VCO_4/XM18/D 0.04454f
C190 DFLIPFLOP_0/XM2/S ua[3] 0.03496f
C191 VDPWR VCO_4/XM9/D 0.01253f
C192 XOR_4/XM9/S BUFFER_0/XM8/G 0
C193 XOR_0/XM9/G BUFFER_1/XM8/S 0
C194 ui_in[5] ui_in[6] 0.03102f
C195 VCO_4/XM21/S BUFFER_4/XM5/S 0
C196 DFLIPFLOP_0/XM9/G ua[3] 0.06323f
C197 XOR_4/XM9/S VCO_3/XM18/D 0.05098f
C198 ui_in[4] ui_in[3] 0.03102f
C199 VCO_7/XM2/G VDPWR 0.06317f
C200 XOR_4/XM9/S VCO_0/XM6/D 0.13472f
C201 rst_n ui_in[0] 0.03102f
C202 XOR_4/XM9/S VCO_2/XM9/D 0.01069f
C203 ua[0] VCO_3/XM9/D 0
C204 XOR_4/XM9/S VCO_2/XM6/D 0.14929f
C205 VCO_1/XM2/G BUFFER_1/XM8/G 0
C206 XOR_4/XM9/S VCO_2/XM2/G 0.06314f
C207 VCO_6/XM8/S VDPWR -0
C208 VCO_5/XM2/G XOR_2/XM9/S 0.00105f
C209 VCO_5/XM18/D VCO_5/XM21/S 0
C210 VCO_1/XM3/D XOR_4/XM9/S 0.01767f
C211 XOR_3/XM9/G XOR_3/XM7/G 0.03521f
C212 XOR_4/XM9/S VCO_1/XM6/D 0.14929f
C213 uio_in[5] uio_in[4] 0.03102f
C214 ua[0] VCO_4/XM6/D 0.00126f
C215 VCO_4/XM18/D BUFFER_4/XM5/S 0
C216 BUFFER_6/XM8/S XOR_2/XM9/S 0.00159f
C217 XOR_4/XM9/S VCO_1/XM9/D 0.01069f
C218 VDPWR BUFFER_4/XM7/D 0.12237f
C219 ua[0] VDPWR 7.45082f
C220 BUFFER_4/XM7/D BUFFER_5/XM8/S 0.00159f
C221 VDPWR VCO_5/XM3/D 0.01742f
C222 DFLIPFLOP_0/XM4/D ua[3] 0.01837f
C223 XOR_0/XM7/G BUFFER_0/XM8/G 0
C224 VDPWR VCO_5/XM6/G 0.01073f
C225 VCO_4/XM16/D VDPWR 0.002f
C226 XOR_3/XM9/D VDPWR 0.09042f
C227 ui_in[6] ui_in[7] 0.03102f
C228 VCO_1/XM2/G VCO_1/XM21/S 0.02355f
C229 VCO_4/XM2/G BUFFER_4/XM8/G 0
C230 VCO_1/XM2/G VCO_1/XM18/D 0
C231 VDPWR XOR_3/XM6/S 0.07485f
C232 VCO_1/XM2/G ua[0] 0.02643f
C233 XOR_4/XM9/S BUFFER_2/XM8/S 0.01192f
C234 VCO_0/XM18/D VCO_0/XM21/S -0
C235 ua[0] VCO_7/XM3/D 0.00337f
C236 XOR_3/XM7/G BUFFER_7/XM8/S 0.00556f
C237 ua[0] VCO_7/XM6/G 0.01393f
C238 VDPWR BUFFER_4/XM5/S 0
C239 VCO_6/XM2/G VDPWR 0.0631f
C240 BUFFER_1/XM5/S VCO_1/XM21/S 0
C241 XOR_4/XM9/S XOR_0/XM7/G 0.38068f
C242 ua[0] VCO_6/XM6/G 0.0486f
C243 BUFFER_1/XM5/S VCO_1/XM18/D 0
C244 VCO_2/XM18/D VCO_2/XM2/G 0
C245 XOR_4/XM9/S VDPWR 0.1487f
C246 ua[2] ua[3] 0.67716f
C247 VCO_7/XM2/G VCO_7/XM6/D -0
C248 ua[0] ua[3] 0.06808f
C249 uio_in[1] uio_in[2] 0.03102f
C250 VDPWR VCO_4/XM18/D -0
C251 VCO_2/XM18/D XOR_4/XM9/S 0.05098f
C252 ua[2] DFLIPFLOP_0/XM5/G 0.00143f
C253 VCO_5/XM2/G BUFFER_5/XM8/G 0
C254 VDPWR VCO_7/XM18/D 0.05098f
C255 XOR_0/XM9/D XOR_0/XM9/G 0
C256 clk rst_n 0.03102f
C257 VCO_0/XM18/D BUFFER_0/XM5/S 0
C258 VCO_1/XM2/G XOR_4/XM9/S 0.06314f
C259 VCO_7/XM6/D ua[0] 0.00988f
C260 XOR_2/XM7/G XOR_2/XM9/G 0.03337f
C261 VCO_7/XM2/G BUFFER_7/XM8/G 0
C262 BUFFER_5/XM5/S XOR_2/XM9/S 0
C263 XOR_1/XM9/G BUFFER_3/XM8/S 0.00755f
C264 VCO_6/XM2/G BUFFER_6/XM5/S 0
C265 VDPWR XOR_6/XM9/D 0.01043f
C266 VDPWR VCO_4/XM6/D 0.1441f
C267 XOR_0/XM7/G VDPWR 0.00226f
C268 VCO_2/XM2/G VCO_2/XM21/S 0.02355f
C269 BUFFER_1/XM5/S XOR_4/XM9/S 0
C270 ua[0] VCO_6/XM6/D 0.00126f
C271 ua[0] VCO_7/XM9/D 0
C272 XOR_4/XM9/S VCO_2/XM21/S 0.00308f
C273 uio_in[0] ui_in[7] 0.03102f
C274 BUFFER_6/XM8/G VCO_6/XM16/D 0
C275 ua[3] DFLIPFLOP_0/XM7/D 0.04817f
C276 XOR_2/XM9/G XOR_2/XM9/S 0.00118f
C277 VCO_2/XM6/G ua[0] 0.04847f
C278 XOR_4/XM9/S VCO_0/XM3/D 0.00922f
C279 VCO_7/XM21/S BUFFER_7/XM5/S 0
C280 XOR_4/XM9/S VCO_0/XM21/S 0.00308f
C281 VDPWR VCO_4/XM7/D 0.002f
C282 BUFFER_6/XM8/S XOR_3/XM9/G 0
C283 BUFFER_6/XM8/G VCO_6/XM18/D 0
C284 VDPWR VCO_7/XM6/G 0.00217f
C285 VCO_5/XM18/D VDPWR -0
C286 VCO_3/XM2/G BUFFER_3/XM8/G 0
C287 VCO_3/XM2/G VCO_3/XM21/S 0.02355f
C288 VCO_5/XM21/S XOR_2/XM9/S 0.00308f
C289 XOR_2/XM7/G BUFFER_4/XM7/D 0
C290 VDPWR VCO_6/XM6/G 0.0129f
C291 VCO_7/XM2/G VCO_7/XM16/D 0
C292 VCO_4/XM8/D VDPWR 0.002f
C293 ua[0] VCO_5/XM9/D 0
C294 uio_in[6] uio_in[7] 0.03102f
C295 BUFFER_6/XM5/S VDPWR 0
C296 VDPWR ua[3] 0.05125f
C297 BUFFER_5/XM8/G VCO_5/XM16/D 0
C298 XOR_4/XM9/S BUFFER_0/XM5/S 0
C299 ua[4] VGND 0.14696f
C300 ua[5] VGND 0.14696f
C301 ua[6] VGND 0.14696f
C302 ua[7] VGND 0.14696f
C303 ena VGND 0.07038f
C304 clk VGND 0.04288f
C305 rst_n VGND 0.04288f
C306 ui_in[0] VGND 0.04288f
C307 ui_in[1] VGND 0.04288f
C308 ui_in[2] VGND 0.04288f
C309 ui_in[3] VGND 0.04288f
C310 ui_in[4] VGND 0.04288f
C311 ui_in[5] VGND 0.04288f
C312 ui_in[6] VGND 0.04288f
C313 ui_in[7] VGND 0.04288f
C314 uio_in[0] VGND 0.04288f
C315 uio_in[1] VGND 0.04288f
C316 uio_in[2] VGND 0.04288f
C317 uio_in[3] VGND 0.04288f
C318 uio_in[4] VGND 0.04288f
C319 uio_in[5] VGND 0.04288f
C320 uio_in[6] VGND 0.04288f
C321 uio_in[7] VGND 0.07391f
C322 XOR_3/XM9/D VGND -0.88175f
C323 XOR_3/XM9/G VGND -1.0744f
C324 XOR_3/XM7/G VGND -1.05002f
C325 XOR_3/XM6/S VGND -0.57061f
C326 XOR_2/XM9/D VGND -0.83089f
C327 XOR_2/XM9/G VGND -0.69507f
C328 XOR_2/XM7/G VGND -1.2051f
C329 XOR_2/XM6/S VGND -0.50069f
C330 XOR_1/XM9/D VGND -0.82841f
C331 XOR_1/XM9/G VGND -1.01628f
C332 XOR_1/XM7/G VGND -1.67365f
C333 XOR_1/XM6/S VGND -0.50068f
C334 XOR_0/XM9/D VGND -0.88343f
C335 XOR_0/XM9/G VGND -1.3163f
C336 XOR_0/XM7/G VGND -1.59316f
C337 XOR_0/XM6/S VGND -0.57108f
C338 BUFFER_7/XM8/S VGND -1.17755f
C339 BUFFER_7/XM8/G VGND -0.7144f
C340 BUFFER_7/XM5/S VGND -0.54899f
C341 ua[2] VGND 5.72098f
C342 DFLIPFLOP_0/XM9/G VGND -0.84835f
C343 DFLIPFLOP_0/XM8/D VGND -0.35026f
C344 DFLIPFLOP_0/XM5/G VGND -0.86233f
C345 DFLIPFLOP_0/XM4/D VGND -0.34501f
C346 DFLIPFLOP_0/XM2/S VGND -0.71783f
C347 DFLIPFLOP_0/XM7/D VGND -0.69157f
C348 ua[3] VGND 5.23001f
C349 VDPWR VGND 37.60796f
C350 BUFFER_6/XM8/S VGND -1.17505f
C351 BUFFER_6/XM8/G VGND -0.7144f
C352 BUFFER_6/XM5/S VGND -0.54899f
C353 BUFFER_5/XM8/S VGND -1.17669f
C354 BUFFER_5/XM8/G VGND -0.7144f
C355 XOR_2/XM9/S VGND -1.38174f
C356 BUFFER_5/XM5/S VGND -0.54939f
C357 BUFFER_4/XM8/S VGND -1.16727f
C358 BUFFER_4/XM8/G VGND -0.71342f
C359 BUFFER_4/XM7/D VGND -2.95753f
C360 BUFFER_4/XM5/S VGND -0.54939f
C361 BUFFER_3/XM8/S VGND -1.17135f
C362 BUFFER_3/XM8/G VGND -0.71433f
C363 BUFFER_3/XM5/S VGND -0.54899f
C364 VCO_7/XM22/D VGND -0.2337f
C365 VCO_7/XM9/D VGND -0.11862f
C366 VCO_7/XM8/S VGND -0.54398f
C367 VCO_7/XM8/D VGND -0.11952f
C368 VCO_7/XM8/G VGND -0.54176f
C369 VCO_7/XM7/D VGND -0.11952f
C370 VCO_7/XM6/G VGND -0.99151f
C371 VCO_7/XM3/D VGND -0.24035f
C372 VCO_7/XM4/D VGND -0.2337f
C373 VCO_7/XM21/S VGND -0.53021f
C374 VCO_7/XM20/D VGND -0.11952f
C375 VCO_7/XM18/D VGND -0.282f
C376 VCO_7/XM7/G VGND -0.54119f
C377 VCO_7/XM2/G VGND -1.31108f
C378 VCO_7/XM16/D VGND -0.07762f
C379 VCO_7/XM5/D VGND -0.2337f
C380 VCO_7/XM6/D VGND -0.09961f
C381 BUFFER_2/XM8/S VGND -1.17572f
C382 BUFFER_2/XM8/G VGND -0.7144f
C383 BUFFER_2/XM5/S VGND -0.54899f
C384 VCO_6/XM22/D VGND -0.2337f
C385 VCO_6/XM9/D VGND -0.11825f
C386 VCO_6/XM8/S VGND -0.54398f
C387 VCO_6/XM8/D VGND -0.11952f
C388 VCO_6/XM8/G VGND -0.54176f
C389 VCO_6/XM7/D VGND -0.11952f
C390 VCO_6/XM6/G VGND -0.94176f
C391 VCO_6/XM3/D VGND -0.23656f
C392 VCO_6/XM4/D VGND -0.2337f
C393 VCO_6/XM21/S VGND -0.53021f
C394 VCO_6/XM20/D VGND -0.11952f
C395 VCO_6/XM18/D VGND -0.282f
C396 VCO_6/XM7/G VGND -0.53853f
C397 VCO_6/XM2/G VGND -1.29954f
C398 VCO_6/XM16/D VGND -0.07762f
C399 VCO_6/XM5/D VGND -0.2337f
C400 VCO_6/XM6/D VGND -0.04417f
C401 BUFFER_1/XM8/S VGND -1.16838f
C402 BUFFER_1/XM8/G VGND -0.71433f
C403 BUFFER_1/XM5/S VGND -0.54899f
C404 VCO_5/XM22/D VGND -0.2337f
C405 VCO_5/XM9/D VGND -0.11825f
C406 VCO_5/XM8/S VGND -0.54398f
C407 VCO_5/XM8/D VGND -0.11952f
C408 VCO_5/XM8/G VGND -0.54176f
C409 VCO_5/XM7/D VGND -0.11952f
C410 VCO_5/XM6/G VGND -0.94176f
C411 VCO_5/XM3/D VGND -0.23656f
C412 VCO_5/XM4/D VGND -0.2337f
C413 VCO_5/XM21/S VGND -0.53021f
C414 VCO_5/XM20/D VGND -0.11952f
C415 VCO_5/XM18/D VGND -0.282f
C416 VCO_5/XM7/G VGND -0.53853f
C417 VCO_5/XM2/G VGND -1.28886f
C418 VCO_5/XM16/D VGND -0.08438f
C419 VCO_5/XM5/D VGND -0.2337f
C420 VCO_5/XM6/D VGND -0.04417f
C421 BUFFER_0/XM8/S VGND -1.17007f
C422 BUFFER_0/XM8/G VGND -0.7144f
C423 BUFFER_0/XM5/S VGND -0.54899f
C424 VCO_4/XM22/D VGND -0.2337f
C425 VCO_4/XM9/D VGND -0.11808f
C426 VCO_4/XM8/S VGND -0.54398f
C427 VCO_4/XM8/D VGND -0.11935f
C428 VCO_4/XM8/G VGND -0.54176f
C429 VCO_4/XM7/D VGND -0.11935f
C430 VCO_4/XM6/G VGND -0.94176f
C431 VCO_4/XM3/D VGND -0.23656f
C432 VCO_4/XM4/D VGND -0.2337f
C433 VCO_4/XM21/S VGND -0.53021f
C434 VCO_4/XM20/D VGND -0.11935f
C435 VCO_4/XM18/D VGND -0.282f
C436 VCO_4/XM7/G VGND -0.53853f
C437 VCO_4/XM2/G VGND -1.28886f
C438 VCO_4/XM16/D VGND -0.08421f
C439 VCO_4/XM5/D VGND -0.2337f
C440 VCO_4/XM6/D VGND -0.04417f
C441 VCO_3/XM22/D VGND -0.2337f
C442 VCO_3/XM9/D VGND -0.1198f
C443 ua[0] VGND 31.46633f
C444 VCO_3/XM8/S VGND -0.54398f
C445 VCO_3/XM8/D VGND -0.11952f
C446 VCO_3/XM8/G VGND -0.54176f
C447 VCO_3/XM7/D VGND -0.11952f
C448 VCO_3/XM6/G VGND -0.94205f
C449 VCO_3/XM3/D VGND -0.23657f
C450 XOR_4/XM9/S VGND -8.24906f
C451 VCO_3/XM4/D VGND -0.2337f
C452 VCO_3/XM21/S VGND -0.53021f
C453 VCO_3/XM20/D VGND -0.11952f
C454 VCO_3/XM18/D VGND -0.282f
C455 VCO_3/XM7/G VGND -0.53858f
C456 VCO_3/XM2/G VGND -1.29984f
C457 VCO_3/XM16/D VGND -0.1031f
C458 VCO_3/XM5/D VGND -0.2337f
C459 VCO_3/XM6/D VGND -0.05316f
C460 VCO_2/XM22/D VGND -0.2337f
C461 VCO_2/XM9/D VGND -0.11826f
C462 VCO_2/XM8/S VGND -0.54398f
C463 VCO_2/XM8/D VGND -0.11952f
C464 VCO_2/XM8/G VGND -0.54176f
C465 VCO_2/XM7/D VGND -0.11952f
C466 VCO_2/XM6/G VGND -0.94205f
C467 VCO_2/XM3/D VGND -0.23657f
C468 VCO_2/XM4/D VGND -0.2337f
C469 VCO_2/XM21/S VGND -0.53021f
C470 VCO_2/XM20/D VGND -0.11952f
C471 VCO_2/XM18/D VGND -0.282f
C472 VCO_2/XM7/G VGND -0.53858f
C473 VCO_2/XM2/G VGND -1.29958f
C474 VCO_2/XM16/D VGND -0.1031f
C475 VCO_2/XM5/D VGND -0.2337f
C476 VCO_2/XM6/D VGND -0.04506f
C477 VCO_1/XM22/D VGND -0.2337f
C478 VCO_1/XM9/D VGND -0.11826f
C479 VCO_1/XM8/S VGND -0.54398f
C480 VCO_1/XM8/D VGND -0.11952f
C481 VCO_1/XM8/G VGND -0.54176f
C482 VCO_1/XM7/D VGND -0.11952f
C483 VCO_1/XM6/G VGND -0.94205f
C484 VCO_1/XM3/D VGND -0.23657f
C485 VCO_1/XM4/D VGND -0.2337f
C486 VCO_1/XM21/S VGND -0.53021f
C487 VCO_1/XM20/D VGND -0.11952f
C488 VCO_1/XM18/D VGND -0.282f
C489 VCO_1/XM7/G VGND -0.53858f
C490 VCO_1/XM2/G VGND -1.28718f
C491 VCO_1/XM16/D VGND -0.1031f
C492 VCO_1/XM5/D VGND -0.2337f
C493 VCO_1/XM6/D VGND -0.04506f
C494 XOR_6/XM9/D VGND -0.88271f
C495 XOR_6/XM6/S VGND -0.56398f
C496 VCO_0/XM22/D VGND -0.2337f
C497 VCO_0/XM9/D VGND -0.11826f
C498 VCO_0/XM8/S VGND -0.54398f
C499 VCO_0/XM8/D VGND -0.11952f
C500 VCO_0/XM8/G VGND -0.54176f
C501 VCO_0/XM7/D VGND -0.11952f
C502 VCO_0/XM6/G VGND -0.94373f
C503 VCO_0/XM3/D VGND -0.23667f
C504 VCO_0/XM4/D VGND -0.2337f
C505 VCO_0/XM21/S VGND -0.53021f
C506 VCO_0/XM20/D VGND -0.11952f
C507 VCO_0/XM18/D VGND -0.282f
C508 VCO_0/XM7/G VGND -0.53858f
C509 VCO_0/XM2/G VGND -1.2996f
C510 VCO_0/XM16/D VGND -0.1031f
C511 VCO_0/XM5/D VGND -0.2337f
C512 VCO_0/XM6/D VGND -0.04554f
C513 XOR_5/XM9/D VGND -0.84786f
C514 XOR_5/XM6/S VGND -0.57069f
C515 XOR_4/XM9/D VGND -0.88423f
C516 XOR_4/XM6/S VGND -0.57392f
.ends
